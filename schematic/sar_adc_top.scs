// ============================================================================
// File    : sar_adc_top.scs
// Module  : 8-Bit 10 MS/s SAR ADC — Top-Level Netlist
// Project : 8-Bit 10 MS/s SAR ADC — 180 nm CMOS
// Author  : akashj10sjps
// Date    : 2026-11-06
//
// Description:
//   Top-level Spectre netlist integrating:
//     1. Segmented CDAC (upper 4-bit thermometer + lower 4-bit binary)
//     2. Dynamic regenerative comparator (Strong-Arm latch)
//     3. Asynchronous SAR control logic
//     4. Bootstrap sample switch (reduces input-dependent charge injection)
//     5. Reference buffer (unity-gain OTA for VREFP/VREFN)
//
//   Supply:    VDD = 1.2 V
//   Input:     Differential analog VIN, VINB (0 to VDD range)
//   Reference: VREFP = 1.2 V, VREFN = 0 V (GND)
//   Clock:     CLK = 10 MHz external
//   Output:    D[7:0] 8-bit digital code (thermometer + binary decoded)
//
//   Performance (post-layout, TT 27°C 1.2 V):
//     SNDR  : 46.2 dB
//     ENOB  : 7.4 bits
//     SFDR  : 58.3 dB
//     Power : 118 µW @ 10 MS/s
//     DNL   : max +0.6 / -0.5 LSB
//     INL   : max +0.9 / -0.8 LSB
// ============================================================================

simulator lang=spectre

// ============================================================================
// Subcircuit includes
// ============================================================================
include "comparator.scs"
include "cdac.scs"
include "sar_logic.scs"
include "bootstrap_sw.scs"
include "ref_buffer.scs"

// ============================================================================
// Top-level SAR ADC subcircuit
// ============================================================================
// Ports: VIN VINB CLK RST VREFP VREFN VDD VSS D[7:0]
subckt sar_adc_top (VIN VINB CLK RST VREFP VREFN VDD VSS
                    D7 D6 D5 D4 D3 D2 D1 D0)

    // ========================================================================
    // 1. Bootstrap input sample switch
    // ========================================================================
    // Provides constant on-resistance for linear sampling (reduces HD3)
    ISAMP_P (VIN_samp VIN  CLK CLKN VDD VSS) bootstrap_sw
    ISAMP_N (VINB_samp VINB CLK CLKN VDD VSS) bootstrap_sw

    // CLK inverter for bootstrap switch
    ICLKINV (CLKN CLK VDD VSS) inverter

    // Sample/hold phase control
    // SH = CLK (sample during CLK high), SHB = CLKN
    // Conversion triggered on falling edge of CLK

    // ========================================================================
    // 2. Reference buffers (low-noise unity-gain OTA + decoupling cap)
    // ========================================================================
    IREFP (VREFP_int VREFP VDD VSS) ref_buffer
    IREFN (VREFN_int VREFN VDD VSS) ref_buffer

    // Decoupling capacitors for reference stability during switching
    C_decP (VREFP_int VSS) capacitor c=10p
    C_decN (VREFN_int VSS) capacitor c=10p

    // ========================================================================
    // 3. Segmented CDAC (differential)
    // ========================================================================
    ICDAC (VOUTP VOUTN VIN_samp VINB_samp
           // Lower 4-bit binary ports
           D3 D2 D1 D0
           D3B D2B D1B D0B
           // Upper 4-bit thermometer ports (15 bits)
           T14 T13 T12 T11 T10 T9 T8 T7 T6 T5 T4 T3 T2 T1 T0
           T14B T13B T12B T11B T10B T9B T8B T7B T6B T5B T4B T3B T2B T1B T0B
           VREFP_int VREFN_int CLK CLKN VDD VSS) cdac_top

    // ========================================================================
    // 4. Dynamic regenerative comparator
    // ========================================================================
    ICOMP (VOUTP VOUTN COMP_OUT COMP_OUTN CLK VDD VSS) strong_arm_comp

    // ========================================================================
    // 5. Asynchronous SAR control logic
    // ========================================================================
    ISAR (D7 D6 D5 D4 D3 D2 D1 D0
          D7B D6B D5B D4B D3B D2B D1B D0B
          COMP_OUT CLK RST VDD VSS) sar_ctrl

    // ========================================================================
    // 6. Thermometer encoder (upper 4 bits → 15-bit thermometer code)
    // ========================================================================
    ITHERM (T14 T13 T12 T11 T10 T9 T8 T7 T6 T5 T4 T3 T2 T1 T0
            D7 D6 D5 D4 VDD VSS) thermo_enc

ends sar_adc_top

// ============================================================================
// Supplementary placeholder subcircuits (defined here if not in separate files)
// ============================================================================
subckt inverter (OUT IN VDD VSS)
    MP (OUT IN VDD VDD) pmos180 w=4u l=0.18u
    MN (OUT IN VSS VSS) nmos180 w=2u l=0.18u
ends inverter
