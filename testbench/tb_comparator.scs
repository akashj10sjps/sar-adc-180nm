// ============================================================================
// File    : tb_comparator.scs
// Module  : Testbench — Dynamic Comparator
// Project : 8-Bit 10 MS/s SAR ADC — 180 nm CMOS
// Author  : akashj10sjps
// Date    : 2026-11-06
//
// Description:
//   Tests the strong-arm latch comparator for:
//     1. Static offset measurement (sweep differential input)
//     2. Dynamic decision latency vs. overdrive voltage
//     3. Kickback noise onto INP/INN
//     4. Power consumption (dynamic only)
//     5. Monte Carlo offset (500 runs — invoke separately)
//
//   Spectre simulation types used:
//     • tran   : waveform inspection, latency, kickback
//     • dc     : operating point
//     • montecarlo: offset distribution (σ_VOS)
// ============================================================================

simulator lang=spectre

include "models/180nm_bulk_tt.scs" section=tt
include "../schematic/comparator.scs"

// ============================================================================
// Supply sources
// ============================================================================
VDD  (VDD  0) vsource dc=1.2
VGND (VSS  0) vsource dc=0

// ============================================================================
// Clock: 10 MHz, 50% duty cycle
// ============================================================================
VCLK (CLK 0) vsource type=pulse val0=0 val1=1.2 period=100n width=50n \
                       rise=100p fall=100p delay=0

// ============================================================================
// Differential input: common mode 0.6 V, overdrive swept from 1 mV to 50 mV
// ============================================================================
// For latency sweep: VCM=0.6 V, VOVD=10 mV (default)
parameters VCM=0.6 VOVD=10m

VINP (INP 0) vsource dc='VCM + VOVD/2'
VINN (INN 0) vsource dc='VCM - VOVD/2'

// ============================================================================
// DUT instantiation
// ============================================================================
XCOMP (INP INN OUTP OUTN CLK VDD VSS) strong_arm_comp

// ============================================================================
// Load capacitances (simulate SAR logic gate input)
// ============================================================================
CL_P (OUTP 0) capacitor c=20f
CL_N (OUTN 0) capacitor c=20f

// ============================================================================
// Simulation control
// ============================================================================
// --- 1. Transient: observe comparison waveforms at 10 mV overdrive ---------
tran_comp tran stop=500n errpreset=conservative \
    save=selected \
    title="Comparator Transient — 10 mV overdrive"

// --- 2. Latency sweep: parametric over overdrive voltage --------------------
// Run from Virtuoso ADE-L → Parametric Analysis → VOVD from 1m to 50m
// Metric: measure(trig v(CLK)>0.6 rise=1) to (targ v(OUTP)>0.6 rise=1)

// --- 3. Kickback noise: probe INP, INN during evaluate ----------------------
// Kickback = integral of |d(INP)/dt| during CLK rise edge

// --- 4. Monte Carlo offset (invoke with montecarlo analyses) ----------------
montecarlo mc numruns=500 seed=1234 donominal=yes variations=all {
    dc_mc dc save=selected
}

// --- 5. Power: average current × VDD during transient ----------------------
// power_avg = average(VDD:p, t1=100n, t2=200n)

// ============================================================================
// Measurements (Spectre .measure equivalents)
// ============================================================================
// Decision latency at 10 mV overdrive (time from CLK→0.5*VDD to OUTP→0.5*VDD)
measureLatency (latency_ns) = delay(v(CLK), 0.6, v(OUTP), 0.6, rise, rise, 1, 1) * 1e9

// Kickback noise amplitude on INP during evaluate phase
measureKickback (kickback_mv) = abs(ymax(deriv(v(INP))) * 1e3)

// Static offset: at which VOVD does OUTP first go high
// (swept via parametric in ADE-L)
